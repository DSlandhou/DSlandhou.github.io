* AVIATION RELAY / CONTACTOR MAINTENANCE TRAINER
* Multisim-compatible SPICE transient simulation netlist
* AC input: L, N, PE. DC input: DC+, DC-.
* KA: 4 NO main contacts + 1 changeover auxiliary contact (1-2 NO, 2-3 NC), 10 A rated.
* KM: 3 NO main contacts + 1 changeover auxiliary contact (1-2 NO, 2-3 NC), 25 A rated.
*
* Simulation schedule:
*   S0 closes at 1 ms; Q1 and Q2 are closed.
*   S1 closes from 0.8 s to 3.2 s (KA operates).
*   S2 closes from 1.6 s to 3.2 s (KM operates).
* To perform manual tests in Multisim, replace V_S1CTL and V_S2CTL PULSE sources with DC 0 or DC 5.

* INPUT SUPPLIES
V_AC          L       N       SIN(0 162.63 400)
V_DC          DCPLUS  DCNEG   DC 28
R_N_REF       N       0       1m
R_PE_REF      PE      0       1m

* CONTROL SIGNALS FOR S0, Q1, Q2, S1 AND S2
V_S0CTL       S0CTL   0       PULSE(0 5 1m 1u 1u 10 20)
V_Q1CTL       Q1CTL   0       DC 5
V_Q2CTL       Q2CTL   0       DC 5
V_S1CTL       S1CTL   0       PULSE(0 5 0.8 1u 1u 2.4 6)
V_S2CTL       S2CTL   0       PULSE(0 5 1.6 1u 1u 1.6 6)

* S0 - DPST MASTER SWITCH: AC POLE AND DC POLE OPERATE TOGETHER
S_S0_AC       L       L_S0    S0CTL   0       SW_ON
S_S0_DC       DCPLUS  DC_S0   S0CTL   0       SW_ON

* POWER-ON INDICATORS (MODELED AS RESISTIVE LAMPS)
R_HL_AC       L_S0    N       5k
R_HL_DC       DC_S0   DCNEG   2.8k

* Q1 - AC MAIN-CIRCUIT BREAKER; Q2 - DC CONTROL-CIRCUIT BREAKER
S_Q1          L_S0    AC_BUS  Q1CTL   0       SW_ON
S_Q2          DC_S0   DC_BUS  Q2CTL   0       SW_ON

* KA CONTROL: S1, 28 VDC COIL AND BLUE OPERATED LAMP (PARALLEL)
S_S1          DC_BUS  KA_COIL S1CTL   0       SW_ON
R_KA_COIL     KA_COIL DCNEG   560
R_HL_KA       KA_COIL DCNEG   2.8k

* KA MAIN CONTACTS a, b, c, d - NORMALLY OPEN; ALL OPERATE TOGETHER
S_KA_A        AC_BUS  KA_A    KA_COIL DCNEG   SW_ON
S_KA_B        AC_BUS  KA_B    KA_COIL DCNEG   SW_ON
S_KA_C        AC_BUS  KA_C    KA_COIL DCNEG   SW_ON
S_KA_D        AC_BUS  KA_D    KA_COIL DCNEG   SW_ON
R_LOAD_KA_A   KA_A    N       2k
R_LOAD_KA_B   KA_B    N       2k
R_LOAD_KA_C   KA_C    N       2k
R_LOAD_KA_D   KA_D    N       2k

* KA AUXILIARY CHANGEOVER CONTACT
* Terminal 2 is common; terminal 1-2 is NO; terminal 2-3 is NC.
R_KA_COM      AC_BUS  KA_2    1m
S_KA_AUX_NO   KA_2    KA_1    KA_COIL   DCNEG  SW_ON
E_KA_NC_CTL   KA_NC_CTL  0    KA_COIL   DCNEG  -1
S_KA_AUX_NC   KA_2    KA_3    KA_NC_CTL 0      SW_NC
R_LOAD_KA_NO  KA_1    N       2k
R_LOAD_KA_NC  KA_3    N       2k

* KM CONTROL: S2, 28 VDC COIL AND BLUE OPERATED LAMP (PARALLEL)
S_S2          DC_BUS  KM_COIL S2CTL   0       SW_ON
R_KM_COIL     KM_COIL DCNEG   280
R_HL_KM       KM_COIL DCNEG   2.8k

* KM MAIN CONTACTS a, b, c - NORMALLY OPEN; ALL OPERATE TOGETHER
S_KM_A        AC_BUS  KM_A    KM_COIL DCNEG   SW_ON
S_KM_B        AC_BUS  KM_B    KM_COIL DCNEG   SW_ON
S_KM_C        AC_BUS  KM_C    KM_COIL DCNEG   SW_ON
R_LOAD_KM_A   KM_A    N       1k
R_LOAD_KM_B   KM_B    N       1k
R_LOAD_KM_C   KM_C    N       1k

* KM AUXILIARY CHANGEOVER CONTACT
* Terminal 2 is common; terminal 1-2 is NO; terminal 2-3 is NC.
R_KM_COM      AC_BUS  KM_2    1m
S_KM_AUX_NO   KM_2    KM_1    KM_COIL   DCNEG  SW_ON
E_KM_NC_CTL   KM_NC_CTL  0    KM_COIL   DCNEG  -1
S_KM_AUX_NC   KM_2    KM_3    KM_NC_CTL 0      SW_NC
R_LOAD_KM_NO  KM_1    N       2k
R_LOAD_KM_NC  KM_3    N       2k

* IDEALIZED CONTACT MODELS
.model SW_ON  SW(Ron=0.05 Roff=1G Vt=15 Vh=0.1)
* The NC switch is ON at 0 V coil drive and OFF when the coil is energized.
.model SW_NC  SW(Ron=0.05 Roff=1G Vt=-1 Vh=0.1)

* ANALYSIS
.tran 50u 4
.end
